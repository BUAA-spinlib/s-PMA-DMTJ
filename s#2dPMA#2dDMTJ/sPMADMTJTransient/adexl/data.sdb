ADE simulation setup
Run mode: Single Run, Sweeps and Corners
Tests:
  haotian:PSA_DMTJ_Simu2:1: haotian/PSA_DMTJ_Simu2_1024/schematic, simulator spectre
