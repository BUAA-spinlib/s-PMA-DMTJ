//Title: Compact model of Double-barrier Perpendicular Shape Anistropy (PSA) MTJ based on Spin transfer torque mechanism
//Version: Beta.3.1
//Date:8 April 2018 ~ 15 April 2018
//Language: VerilogA

/*-------------------------------------------
Property: Beihang University
Authors: Haotian WANG, Wang Kang, You WANG, Youguang Zhang，and Weisheng ZHAO
---------------------------------------------*/
`resetall
`include "constants.vams"
`include "disciplines.vams"
`define explimit 85.0
`define exp(x) exp(min(max((x),-`explimit),`explimit))
`define sqrt(x) pow( (x), 0.5)

`define rec 1
`define ellip 2
`define circle 3

`define e 1.6e-19
`define ub 9.27e-24
`define Kb 1.38e-26
`define m 9.10e-31
`define C 0.577

module PSA_DMTJ(T1,T2,x,Ttrans,PI,Temp);

inout T1, T2;
electrical T1, T2;
electrical n1,n2;

inout x,Ttrans,PI,Temp;
electrical x,Ttrans,PI,Temp;

parameter real  alpha=0.005;
parameter real  gamma=1.76e11;
parameter real  P=0.57;
parameter real  Ms=1209616;
parameter real  PhiBas=0.4;
parameter real  Vh=0.5;
parameter real  tsl=15e-9 from[0.7e-9:30e-9];
parameter real  a=10e-9;
parameter real  b=10e-9;
parameter real  r=5.25e-9;
parameter real  toxb=8.5e-10 from[8e-10:2e-9];
parameter real  toxt=2.5e-10 from[0:3.0e-10];
parameter real  TMR=1.0;
parameter real 	SHAPE=3  from[1:3];
parameter real 	tau0=8.7e-10;
parameter real	Ps=0.999999;
parameter real brown_threshold=0.0;
parameter integer 	PAP=0 from[0:1];
parameter real 		T= 300;
parameter real 		RA=4.5 from[4:15];
parameter real 		Cv= 2.74e6  from[2.735e6:2.7805e6];
parameter real 		lam= 84.897 from [84.8912:84.9449];
parameter real 		thick_s= 3.355e-8;
parameter real resistor=100e6;
parameter real coeff_tau=12;

real capacitor;
real tau_th;
real temp;
real temp_init;
real R;

parameter real p=1.0;
parameter integer STO=0 from[0:2];
parameter integer RV=0 from[0:2];
parameter integer DC=0 from[0:1];
parameter integer Temp_var=0 from[0:1];
parameter real DEV_toxb=1e-10;
parameter real DEV_toxt=1e-11;
parameter real DEV_tsl=1e-9;
parameter real DEV_TMR=1e-1;
parameter real STO_dev=1e-10;

real g_STT;
real surface;
real gp;
real gap;
real TMRR;
real TMRRT;
real Rob;
real Rot;
real Rap;
real Rp;
real Vb;
real Vc;
real Id;
real IcAP;
real IcP;
integer ix;
real tau;
real FA;
integer seed;
real durationstatic,duration;
real toxbreal;
real toxtreal;
real tslreal;
real TMRreal;
real pp;
(*cds_inherited_parameter*)parameter real seedin = 0;
real VPI;
real P_APt;
real AP_Pt;
integer rec_time;

	real q;
	real qx;
	real fx, fy,fz;
	parameter real u_0 = 4*`M_PI*1.0e-7;
	parameter real Kp = 0;
	parameter real Ki = 2.2e-6;
	real Keff;
	real Em;
	real EE;
	real Ebm;
	real theta;

analog begin

	if (SHAPE==1)
		begin
		surface=a*b;
		end
		else if (SHAPE==2)
		begin
		surface=`M_PI*a*b/4;
		end
		else
		begin
		surface=`M_PI*r*r;
	end

	Vc=V(T2,T1);
	Vb=V(T1,T2);

@(initial_step)
begin

	seed=1000000000*seedin;

	FA=3322.53/RA;

	if (RV==1)
		begin
			toxbreal=$rdist_uniform(seed,toxb*0.99,toxb*1.01);
			toxtreal=$rdist_uniform(seed,toxt*0.99,toxt*1.01);
			tslreal=$rdist_uniform(seed,tsl*0.99,tsl*1.01);
			TMRreal=$rdist_uniform(seed,TMR*0.99,TMR*1.01);
		end
	else if (RV==2)
		begin
			toxbreal=abs($rdist_normal(seed,toxb,DEV_toxb));
			toxtreal=abs($rdist_normal(seed,toxt,DEV_toxt));
			tslreal=abs($rdist_normal(seed,tsl,DEV_tsl));
			TMRreal=abs($rdist_normal(seed,TMR,DEV_TMR));
		end
	else
		begin
			toxbreal=toxb;
			toxtreal=toxt;
			tslreal=tsl;
			TMRreal=TMR;
		end
	temp=T;
        temp_init=T;

        tau_th= Cv*thick_s / (lam/thick_s);

        capacitor=coeff_tau*tau_th/resistor;

	Rob=(toxbreal*1.0e10/(1.0e12*FA*`sqrt(PhiBas)*surface))*exp(1.025*toxbreal*1.0e10*`sqrt(PhiBas));
	Rot=(toxtreal*1.0e10/(1.0e12*FA*`sqrt(PhiBas)*surface))*exp(1.025*toxtreal*1.0e10*`sqrt(PhiBas));
	q = tslreal/(2*r);
	if (q>=1)
		begin
			qx= 1- 1/(q*q);
			fz = ((-`sqrt(qx*qx*qx)/3-`sqrt(qx)-0.5*ln(1-`sqrt(qx))+0.5*ln(1+`sqrt(qx)))/(`sqrt(qx*qx*qx))+0.333)*(1-qx);
			fx = (1-fz)/2;
		end
	else
		begin
			fx = (q*q/(2*(1-q*q)))*((1/(q*(`sqrt(1-q*q))))*acos(q)-1);
			fz = 1-fx*2;
		end

	Keff = Kp - u_0*Ms*Ms*(130/126)*(1.0e-3)*(fz-fx)/2;
	Em = (Keff*tslreal+Ki)*surface*1000;

	duration=0.0;
	P_APt=0;
	AP_Pt=0;

        if(DC==0)
	    begin
	      ix=-PAP;
	      I(x)<+ PAP;
	      VPI=p;
	      I(PI)<+p;
	    end
        else
	    begin
	      ix=PAP;
	    end

        V(Ttrans)<+PAP;
        I(T1,T2)<+Id;

end

if(Temp_var==0)
   begin
      temp=temp_init;
   end
else
   begin
      temp=V(Temp);
   end

EE=Em/(`Kb*temp);
Ebm=Em*1.0e22;
	theta = `sqrt(0.5/EE);

if(DC==1)
	begin

		if(ix==0)
			begin
				TMRR=TMRreal/(1+Vb*Vb/(Vh*Vh));
				Rp=Rob + Rot*(1+TMRreal);
				R=Rp;
				Id=Vb/Rp;
				g_STT = P/(1-(P*P*P*P)*((cos(theta))*(cos(theta))));
				gp=2*alpha*gamma*`e*Em/(surface*`ub*g_STT);
				IcP=gp*surface;
				if(Vb<(IcP*Rp))
					begin
						ix=0.0;

					end
				else
					begin
						ix=1.0;

					end
			end
		else
			begin
				TMRRT=TMRreal/(1+Vb*Vb/(Vh*Vh));
				Rap=Rob*(1+TMRRT)+Rot;
				R=Rap;
				Id=Vb/(Rap);
				g_STT = P/(1-(P*P*P*P)*((cos(theta))*(cos(theta))));
				gap=2*alpha*gamma*`e*Em/(surface*`ub*g_STT);
				IcAP=gap*surface;
				if(Vc>=(IcAP*Rap))
					begin
						ix=0.0;
					end
			end
                V(Ttrans)<+ix;
                I(T1,T2)<+Id;
    end
else
	begin

        if(STO==1||STO==2)
         begin

	if(I(Ttrans)==0)
		begin

			if (pp==1)
				begin
					VPI=1;
					pp=0;
				end
			TMRR=TMRreal/(1+Vb*Vb/(Vh*Vh));
			Rp=Rob+Rot*(1+TMRreal);
			R=Rp;
			Id=Vb/Rp;

			if(ix==0)
				begin
					g_STT = P/(1-(P*P*P*P)*((cos(theta))*(cos(theta))));
					gp=2*alpha*gamma*`e*Em/(surface*`ub*g_STT);
					IcP=gp*surface;

					if(Vb>=IcP*Rp)
						begin
							durationstatic=(`C+ln(`M_PI*`M_PI*(EE)/4))*`e*Ms*surface*tslreal*(1+P*P)/(2*`ub*P*abs(Id-IcP));
							if(STO==1)
								begin
									duration=abs($rdist_exponential(seed, durationstatic));
								end
							else if(STO==2)
							        begin
									duration=abs($rdist_normal(seed,durationstatic,STO_dev));

								end

							else
								begin
									duration=durationstatic;
								end

							if(duration<($abstime-P_APt))
								begin

									if(duration>VPI)
										begin
											ix=-1.0;
											pp=1;
										end
									else
										begin
											VPI=duration;
											duration= 100000000;
										end
								end
						end

					else
						begin

				    			ix=0.0;
							tau=tau0*exp(Em*(1-abs(Id/IcP))/(`Kb*temp));
							if(Vb>brown_threshold)
								begin
									if (Vb<0.8*IcP*Rp)
										begin

											if(STO==1)
												begin
													duration=abs($rdist_exponential(seed, tau));
												end
											else if(STO==2)
							                                        begin
									                                duration=abs($rdist_normal(seed, durationstatic,STO_dev));
											        end
											else
												begin
													duration=tau;
												end
											if (($abstime-P_APt) > duration)
					  							begin
													if(VPI<=duration)
														begin
															ix=-1.0;
														end
													else
														begin
															VPI=duration;
															duration= 100000000;
														end
												end
										end
								end
						end
				end

	end

	if(I(Ttrans)!=0)
		begin

			if (pp==1)
				begin
					VPI=1;
					pp=0;
				end
			TMRRT=TMRreal/(1+Vb*Vb/(Vh*Vh));
			Rap=Rob*(1+TMRRT)+Rot;
			R=Rap;
			Id=Vb/(Rap);

			if(ix!=0)
				begin
					g_STT = P/(1-(P*P*P*P)*((cos(theta))*(cos(theta))));
					gap=2*alpha*gamma*`e*Em/(surface*`ub*g_STT);
					IcAP=gap*surface;
					if(Vc>=(IcAP*Rap))
						begin
							durationstatic=(`C+ln(`M_PI*`M_PI*(Em/(`Kb*temp))/4))*`e*Ms*surface*tslreal*(1+P*P)/(2*`ub*P*abs(-Id-IcAP));
							if(STO==1)
								begin
									duration=abs($rdist_exponential(seed, durationstatic));
								end
							else if(STO==2)
							        begin
							                duration=abs($rdist_normal(seed, durationstatic,STO_dev));

			                                        end
							else
								begin
									duration=durationstatic;
								end
							if(duration<($abstime-AP_Pt))
								begin
									if(VPI<=duration)
										begin
											ix=0.0;
											pp=1;
										end
									else
										begin
											VPI=duration;
											duration= $abstime-AP_Pt;
										end
								end
						end
					else
						begin

	    						ix=-1.0;
							tau=tau0*exp(Em*(1-abs(Id/IcAP))/(`Kb*temp));
							if(Vc>brown_threshold)
								begin
									if (Vc<0.8*IcAP*Rap)
										begin
											if(STO==1)
												begin
													duration=abs($rdist_exponential(seed, tau));
                                                                                                end
											else if(STO==2)
							                                        begin
									                                duration=abs($rdist_normal(seed, durationstatic,STO_dev));
												end

											else
												begin
													duration=tau;
												end

											if (duration<($abstime-AP_Pt))
					  							begin

													if(VPI<=duration)
														begin
															ix=0.0;
														end
													else
														begin
															VPI=duration;
															duration= 100000000;
														end

												end
										end

								end
						end

				end

	end

end

else
begin

if(I(Ttrans)==0)
		begin
			if (pp==1)
				begin
					VPI=1;
					pp=0;
				end
			TMRR=TMRreal/(1+Vb*Vb/(Vh*Vh));
			Rp=Rob+Rot*(1+TMRreal);
			R=Rp;
			Id=Vb/Rp;
					g_STT = P/(1-(P*P*P*P)*((cos(theta))*(cos(theta))));
					gp=2*alpha*gamma*`e*Em/(surface*`ub*g_STT);
					IcP=gp*surface;
					if(Vb>=IcP*Rp)
						begin
							durationstatic=(`C+ln(`M_PI*`M_PI*(Em/(`Kb*temp))/4000))*`e*Ms*surface*tslreal*(1+P*P)/(2*`ub*P*abs(Id-IcP));
							duration=durationstatic;
							if(duration<($abstime-P_APt))
								begin
									ix=-1.0;
								end
							else
								begin
									ix=0.0;
								end

						end
					else
						begin
				    			ix=0.0;
							tau=tau0*exp(Em*(1-abs(Id/IcP))/(`Kb*temp));
							if(Vb>brown_threshold)
								begin
									if (Vb<0.8*IcP*Rp)
										begin
											duration=tau;
											if (($abstime-P_APt) > duration)
					  							begin
													ix=-1.0;
												end
											else
												begin
													ix=0.0;
												end

										end
								end
						 end
	        end

	else if(I(Ttrans)!=0)

		begin

			if (pp==1)
				begin
					VPI=1;
					pp=0;
				end
			TMRRT=TMRreal/(1+Vb*Vb/(Vh*Vh));
			Rap=Rob*(1+TMRRT)+Rot;
			R=Rap;
			Id=Vb/(Rap);
					g_STT = P/(1-(P*P*P*P)*((cos(theta))*(cos(theta))));
					gap=2*alpha*gamma*`e*Em/(surface*`ub*g_STT);
					IcAP=gap*surface;

					if(Vc>=(IcAP*Rap))
						begin
							durationstatic=(`C+ln(`M_PI*`M_PI*(Em/(`Kb*temp))/4000))*`e*Ms*surface*tslreal*(1+P*P)/(2*`ub*P*abs(-Id-IcAP));
							duration=durationstatic;
							if(duration<($abstime-AP_Pt))
								begin
									ix=0.0;
								end
							else
								begin
									ix=-1.0;
								end
						end
					else
						begin
	    						ix=-1.0;
							tau=tau0*exp(Em*(1-abs(Id/IcAP))/(`Kb*temp));
							if(Vc>brown_threshold)
								begin
									if (Vc<0.8*IcAP*Rap)
										begin
											duration=tau;
											if (duration<($abstime-AP_Pt))
					  							begin
													ix=0.0;
												end
											else
												begin
													ix=-1.0;
												end

										end

								end
						end

	end

end

@(cross(Id-IcP,+1))
begin
	P_APt = $abstime;
end

@(cross(-Id-IcAP,+1))
begin
	AP_Pt = $abstime;
end

I(x)<+ix;
I(Ttrans)<+transition(ix,0,1e-14,1e-14);
I(T1,T2)<+Id;
I(PI)<+VPI;

if(Temp_var==1)
    begin
      V(n1) <+ ( V(T1,T2)*V(T1,T2) )/ ( R*surface*lam/(thick_s ));
      I(n1,n2) <+ V(n1,n2) / resistor;	//RC circuit parallel
      I(n2) <+ capacitor * (ddt(V(n2)));
      V(Temp) <+  V(n2) + temp_init;
    end
else
    begin
      V(Temp) <+  temp_init;
    end
end
end
endmodule
