ADE simulation setup
Run mode: Single Run, Sweeps and Corners
Tests:
  s-PMA-DMTJ:PSA_DMTJ_Simu:1: s-PMA-DMTJ/sPMADMTJDCSimu/schematic, simulator spectre
