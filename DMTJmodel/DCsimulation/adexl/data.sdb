ADE simulation setup
Run mode: Monte Carlo Sampling
Tests:
  PMAMTJ40symRp:DCsimulation:1: PMAMTJ40symRp/DCsimulation/schematic, simulator spectre
Monte Carlo Sampling options: mcmethod=all, mcnumpoints=100, limit_on_outstanding_points=40
