//Title: Compact model of double barrier MTJ based on Spin transfer torque mechanism
//Version: Beta.3.0
//Date:21 April 2019
//Language: VerilogA

/*-------------------------------------------
Property:  Beihang University
Authors: Guanda Wang, Yue ZHANG, Weisheng ZHAO, Dafine Ravelosona, Jacques-Olivier Klein and Claude Chappert

In this model, it takes into account the static, dynamic and stochastic behavoirs of double barrier MTJ nanopillar

1.MTJ resistance calculation based on brinkman model
2.TMR dependence on the bias voltage
3.Spin polarity calculation model for magnetic tunnel junction
4.Critical current calculation
5.Sun model (>critical current)
6.Neel-Brown model (<critical current)

The parameters are from the prototypes of Univ. Tohuku

---------------------------------------------*/
`resetall
`include "constants.vams"
`include "disciplines.vams"
`define explimit 85.0
`define exp(x) exp(min(max((x),-`explimit),`explimit))
`define sqrt(x) pow( (x), 0.5)

//Shape definition
`define rec 1
`define ellip 2
`define circle 3

/*-------------------------------------------
Electrical Constants
---------------------------------------------*/

/*----------Elementary Charge---------------*/
`define e 1.6e-19
/*----------Bohr Magnetron Costant----------*/
`define ub 9.27e-28
/*----------Boltzmann Constant------------- */
`define kB 1.38e-23
/*----------Electron Mass------------- */
`define m 9.10e-31
/*----------Euler's constant---------------*/
`define C 0.577

`define u0 1.2566e-6

module Model(T1,T2,x,Ttrans,PI,Temp);

inout T1, T2;
electrical T1, T2;
electrical n1,n2;    //virtual terminals of RC circuit for time modelisation for temperature

/*----------X=store the state of the MTJ, non-volatile way------------- */
/*----------Ttrans=store the state of the MTJ with time influence, non-volatile way------------- */
/*----------PI=switching probability------------- */
/*----------Temp=store the temperature------------- */
inout x,Ttrans,PI,Temp;
electrical x,Ttrans,PI,Temp;

/*------------------------------------------
MTJ Technology Parameters
(Corresponds to the HITACHI MTJ Process)
-------------------------------------------*/

/*----------bulk Gilbert Damping Coefficient---------------*/
parameter real  alpha=0.004;
/*----------GyroMagnetic Constant in Hz/Oe---------------*/
parameter real  gamma=1.76e7;
/*----------Electron Polarization Percentage % ---------------*/
parameter real  P=0.71;

/*----------Saturation Field in the Free Layer in T---------------*/
parameter real  Ms0=1.58;
/*----------The Energy Barrier Height for MgO in electron-volt---------------*/
parameter real  PhiBas=0.4;
/*----------Voltage bias when the TMR(real) is 1/2TMR(0) in Volt---------------*/
parameter real  Vh=0.5;		//experiental value with MgO barrier
/*----------Current Pulse width in second---------------*/
parameter real  Pwidth=1e-8;

/*------------------------------------------
Device Parameters
(Corresponds to the HITACHI 240 x 80 MTJ)
-------------------------------------------*/
/*----------Height of the top Free Layer  in nm---------------*/
parameter real  tflt=1.6e-9 from[1.0e-9:1.6e-9];
/*----------Height of the bottom Free Layer  in nm---------------*/
parameter real  tflb=1.6e-9 from[1.0e-9:1.6e-9];
/*----------Length in nm---------------*/
parameter real  a=20e-9;
/*----------Width in nm---------------*/
parameter real  b=20e-9;
/*----------Radius in nm---------------*/
parameter real  r=20e-9;
/*----------Height of the bottom Oxide Barrier in nm---------------*/
parameter real  toxb=8e-10 from[8e-10:15e-10];
/*----------Height of the top Oxide Barrier in nm---------------*/
parameter real  toxt=4e-10 from[2e-10:4e-10];
/*----------TMR(0) with Zero Volt Bias Voltage ---------------*/
parameter real  TMR=1.8;

/*----------Shape of MTJ---------------*/
parameter real 	SHAPE=2  from[1:3];  //SQUARE

/*----------Neel-Brown model parameter ---------------*/
parameter real 	tau0=8.7e-10;	//experimental value, prototype Hitachi 2007m with CoFe layer

/*----------Error probability Ps=1-Pr(t) ----------------*/
parameter real	Ps=0.999999;

/*----------Threshold for Neel-Brown model----------------*/
parameter real brown_threshold=0.0;
/*----------interface PMA enery density in J/m2----------------*/
parameter real Ki0=1.3e-3 from[1.0e-3:3e-3];
/*----------bulk PMA energy J/m3----------------*/
parameter real Kb0=1.8e5 ;
/*----------MTJ State Parameters----------------*/
/*----------Initial state of the MTJ, 0 = parallele, 1 = anti-parallele----*/
parameter integer 	PAP=0 from[0:1];

parameter integer STO=0 from[0:1];
/*----------Resistance area product in ohmum2----------------*/
parameter real 		RAt=10 from[0.5:10];
parameter real 		RAb=10 from[5:20];

parameter real          As=19e-12;
parameter integer DC=0 from[0:1];

parameter integer Temp_var=0 from[0:1];     //choice of time modelisation for temperature
/*----------Parameters of RC circuit for time modelisation for temperature---------------*/
/*----------Heat capacity per unit volume in J/m3*K----------------*/
parameter real 		Cv= 2.74e6  from[2.735e6:2.7805e6];
/*----------Thermal conductivity of the thermal barrier(MgO) in W/m*K----------------*/
parameter real 		lam= 84.897 from [84.8912:84.9449];//

/*----------Total thickness of MTJ nanopillar in nm----------------*/
parameter real 		thick_s= 3.355e-8;//
/*----------RC circuit for time modelisation for temperature---------------*/
parameter real resistor=100e6; //R=100M
parameter real coeff_tau=12; //Coefficient to increase tau_th

real capacitor;   //virtual capacitor
real tau_th;        //characteristic heating/cooling time
real temp;    //real temperature of MTJ
real temp_init;   //temperature initialised

real delay;
parameter real p=1.0;

parameter integer       RV=0 from[0:1];          //choice of stochastic static intrinsically, 0 no stochastic, 1 random gauss distribution

/*---------Parameters for stochastic behaviors---------------*/

parameter real DEV_toxt=0.03;
parameter real DEV_toxb=0.03;        //variability of stochastic static gauss distribution for tox
parameter real DEV_tflt=0.03;
parameter real DEV_tflb=0.03;        //variability of stochastic static gauss distribution for tsl
parameter real DEV_TMR=0.03;        //variability of stochastic static gauss distribution for TMR
parameter real STO_dev=0.03;

/*---------Parameters for Tempreature dependented TMR-------------*/

parameter real 		T= 300;//Room temperature in Kelvin;
parameter real 		T0=300;
parameter real          Q=0.025;
parameter real          Ec=4.32e-23;
parameter real          S=1.5;
parameter real          Em0=1.936e-20;

//variables

//STT efficiency for the two states of DMTJ
real g; 	//STT efficiency of DMTJ

real dwt; 	//domain wall width of DMTJ
real dwb; 	//domain wall width of DMTJ
real surface;	//Surface of MTJ

real Emt;
real Emb;
real Em,EE; 	//Variable of the Slonczewski model

//TMR real value for the two states of DMTJ
real TMRR;	//TMR real value with bias voltage

//Resistance of MTJ
real Rpt;	//Resistance of top MTJ in P
real Rapt;	//Resistance of top MTJ in AP
real Rpb;	//Resistance of bottom MTJ in P
real Rapb;	//Resistance of bottom MTJ in AP
real R0;	//Resistance value for 0 state
real R1;	//Resistance value for 1 state

real Vb;	//V(T1,T2)
real Vc;	//V(T2,T1)

real Kefft;
real Keffb;// effective PMA energy of top/bottom free layer of DMTJ

real Kdemt;
real Kdemb;// demagnetic energy of top/bottom free layer of DMTJ
real Nxt;
real Nyt;
real Nzt;  // demagnetization factors of top FL;
real Nxb;
real Nyb;
real Nzb;  // demagnetization factors of bottom FL;
real bt ;  // the diameter/tickness factor of the top FL;
real bb ;    // the diameter/tickness factor of the bottom FL;

real Id;	//Current of MTJ

//critial current for the two states of DMTJ
real Ic0; 	//Critial current in state 0
real Ic1;       //Critial current in state 1
integer ix;	//Current used to store the state of the MTJ

real tau;	//Probability parameter

real FAt;
real FAb; //Factor for calculating the resistance based on RA
real Ms;
real Ki;
real Kb;

real durationstatic,duration;	//time needed to be sure that the switching is effected

real toxtreal;   //real thickness of top oxide layer
real toxbreal;   //real thickness of bottom oxide layer
real tfltreal;   //real thickness of top free layer
real tflbreal;   //real thickness of bottom free layer
real tfltotal;
real TMRreal;	//real TMR

analog begin

	if (SHAPE==1)
		begin
		surface=a*b;	//SQUARE
		end
		else if (SHAPE==2)
		begin
		surface=`M_PI*a*b/4;	//ELLIPSE
		end
		else
		begin
		surface=r*r;    //ROUND
	end

	Vc=V(T2,T1);	//potential between T2 and T1
	Vb=V(T1,T2);	//potential between T2 and T1

//initial conditions
@(initial_step)
begin

	FAt=3322.53/RAt;	//initialization of resistance factor according to RA product
        FAb=3322.53/RAb;        //initialization of resistance factor according to RA product

		begin
			toxtreal=toxt;
                        toxbreal=toxb;
			tfltreal=tflt;
                        tflbreal=tflb;
			TMRreal=TMR;
	    end

                       tfltotal=tfltreal+tflbreal;

					   temp=T;
        temp_init=T;

        tau_th= Cv*thick_s / (lam/thick_s);

        capacitor=coeff_tau*tau_th/resistor;	//tau_th=resistor*capacitor

if(Temp_var==0)
   begin
      temp=temp_init;        //temperature constant
   end
else
   begin
      temp=V(Temp);          //time modelisation for temperature
   end

	Rpt=(toxtreal*1.0e10/(FAt*`sqrt(PhiBas)*surface*1.0e12))*exp(1.025*toxtreal*1.0e10*`sqrt(PhiBas));

        Rpb=(toxbreal*1.0e10/(FAb*`sqrt(PhiBas)*surface*1.0e12))*exp(1.025*toxbreal*1.0e10*`sqrt(PhiBas));
//resistance of the top and bottom MTJ in P
        Ms=Ms0*(1-(T/1120)*sqrt(T/1120))/(1-(T0/1120)*sqrt(T0/1120));
        Ki=Ki0*pow(Ms/1.58,2.18);
        Kb=Kb0*pow(Ms/1.58,2.18);
        bt= a/tfltreal;
        Nzt=bt*bt/(bt*bt-1)*(1-asin(sqrt(bt*bt-1)/bt/sqrt(bt*bt-1)));
        Nxt=0.5*(1-Nzt);
        Nyt=0.5*(1-Nzt);
        Kdemt=Ms*Ms/2/`u0*(Nzt-Nyt-Nxt);

        Kefft=Kb-Kdemt+Ki/tfltreal;

        bb= a/tflbreal;
        Nzb=bb*bb/(bb*bb-1)*(1-asin(sqrt(bb*bb-1)/bb/sqrt(bb*bb-1)));
        Nxb=0.5*(1-Nzb);
        Nyb=0.5*(1-Nzb);
        Kdemb=Ms*Ms/2/`u0*(Nzb-Nyb-Nxb);

        Keffb=Kb-Kdemb+Ki/tflbreal;
        dwt=`M_PI*`sqrt(As/Kefft);
        dwb=`M_PI*`sqrt(As/Keffb);

if (a<dwt)
        begin
        Emt=Kefft*tfltreal*surface;

        end
else
        begin
        Emt=Kefft*tfltreal*`M_PI*dwt*dwt/4;
        end
if (a<dwb)
        begin
        Emb=Keffb*tflbreal*surface;

        end
else
        begin
        Emb=Keffb*tflbreal*`M_PI*dwb*dwb/4;
        end
	Em=Emt+Emb;
	EE=Em/(`kB*T);  //result of E/kBT

	duration=1.0;

if(DC==0)
	begin
	//States inititialisation
	ix=-PAP;
	I(Ttrans)<+PAP;

	end
else
	begin
	ix=PAP;
	end

end

$display("the value of Ic0 is %g", Ic0, "the value of Ic1 is %g", Ic1,"the value of Voltage is %g", Vb,  "the value of R0 is %g", R0,  "the value of R1 is %g", R1,  "the value of EE is %g",EE,  "the value of swithing time is %g",duration,"the value of tflt is %g", tfltreal,"the value of tflb is %g", tflbreal,"the value of toxt is %g", toxtreal,"the value of toxb is %g", toxbreal,"the value of TMRR is %g",TMRR,"the value of Ms is %g",Ms,"the value of Ki is %g",Ki,"the value of T is %g",T);

if(DC==1)
	begin

		if(ix==0)	//Case which the state of DMTJ is 0
			begin
				TMRR=((1+TMRreal)*(1+2*Q*S*`kB*300/Em0/0.305*ln(`kB*300/Ec))/(1+2*Q*S*`kB*T/Em0/0.305*ln(`kB*T/Ec))-1)/(1+Vb*Vb/(Vh*Vh));

				Rapt=Rpt*(1+TMRreal);
				R0=Rapt+Rpb;				//state 0 resistance
				Id=Vb/R0;

				//Calcul of critical current
				g=P/(1-P*P*P*P*cos(0)*cos(0));  	//STT efficiency of DMTJ

				Ic0=2*alpha*gamma*`e*(Kefft*tfltreal*surface+Keffb*tflbreal*surface)/(`ub*g); 	//	//Critical current

				if(Vb<(Ic0*R0))
					begin
						ix=0.0;

					end
				else
					begin
						ix=1.0;

					end
			end
		else
			begin
				//TMR real
				TMRR=((1+TMRreal)*(1+2*Q*S*`kB*300/Em0/0.305*ln(`kB*300/Ec))/(1+2*Q*S*`kB*T/Em0/0.305*ln(`kB*T/Ec))-1)/(1+Vb*Vb/(Vh*Vh));

				// State 1
                                Rapb=(1+TMRR)*Rpb;

				R1=Rpt+Rapb;
				Id=Vb/(R1);
				g=P/(1-P*P*P*P*cos(`M_PI)*cos(`M_PI));  //STT efficiency of DMTJ

				Ic1=2*alpha*gamma*`e*(Kefft*tfltreal*surface+Keffb*tflbreal*surface)/(`ub*g);  	//Critical current
				if(Vc>=(Ic1*R1))
					begin
						ix=0.0;
					end
			end

V(Ttrans)<+ix;

I(T1,T2)<+Id;	//Actualisation of the current of MTJ with the value calculated

end

else
	begin

if(I(Ttrans)==0)	//Case which the magnetizations of the two layers are parallel
		begin

			//TMR real
		TMRR=((1+TMRreal)*(1+2*Q*S*`kB*300/Em0/0.305*ln(`kB*300/Ec))/(1+2*Q*S*`kB*T/Em0/0.305*ln(`kB*T/Ec))-1)/(1+Vb*Vb/(Vh*Vh));

				Rapt=Rpt*(1+TMRreal);
				R0=Rapt+Rpb;				//state 0 resistance
				Id=Vb/R0;

				//Calcul of critical current
				g=P/(1-P*P*P*P*cos(0)*cos(0));  	//STT efficiency of DMTJ

				Ic0=2*alpha*gamma*`e*(Kefft*tfltreal*surface+Keffb*tflbreal*surface)/(`ub*g); 	//Critical current

       if(Vb>=Ic0*R0)
	                      begin	                //Current higher than critical current

							//STT-MTJ dynamic behavior : Sun model

							//Time needed to be sure that the switching is effected
							durationstatic=(`C+ln(`M_PI*`M_PI*EE/4))*`e*1000*Ms*10000*surface*tfltotal/(4*`M_PI*4*g*`ub*10000*(abs(Id)-Ic0));

							$display("durationstatic=",durationstatic);

								begin
									duration=durationstatic;
								end

							if(duration<=Pwidth)
								begin	//Switching of the free layer always occurs

											ix=-1.0;   //change the current state of MTJ

										end
									else
										begin
											ix=0.0;

										end

						end

					else
						begin	//Current smaller than critical current

							tau=tau0*exp(Em*(1-abs(Id/Ic0))/(`kB*T));
							Id=Vb/R0;
							if(Vb>brown_threshold)
								begin
									if (Vb<0.8*Ic0*R0)
										begin

							       begin
								    duration=tau;
							       end

											if (Pwidth >=duration)
					  							begin

															ix=-1.0;   //change the current state of MTJ
														end
													else
														begin
															ix=0.0;
														end

										end
								end
						end

	end

	if(V(Ttrans)!=0)  	//Case which the magnetizations of the two layers are antiparallel
		begin

			//TMR real
			TMRR=((1+TMRreal)*(1+2*Q*S*`kB*300/Em0/0.305*ln(`kB*300/Ec))/(1+2*Q*S*`kB*T/Em0/0.305*ln(`kB*T/Ec))-1)/(1+Vb*Vb/(Vh*Vh));

				// State 1
                                Rapb=(1+TMRR)*Rpb;

				R1=Rpt+Rapb;
				Id=Vb/(R1);

				g=P/(1-P*P*P*P*cos(0)*cos(0));  //STT efficiency of DMTJ

				Ic1=2*alpha*gamma*`e*(Kefft*tfltreal*surface+Keffb*tflbreal*surface)/(`ub*g); //Critical current

					if(Vc>=(Ic1*R1))
						begin	//Current higher than critical current

							//STT-MTJ dynamic behavior : Sun model
									durationstatic=(`C+ln(`M_PI*`M_PI*EE/4))*`e*1000*Ms*10000*surface*tfltotal/(4*`M_PI*4*g*`ub*10000*(abs(Id)-Ic1));
							//time needed to be sure that the switching is effected

								begin
									duration=durationstatic;
								end
if(duration<=Pwidth)
								begin	//Switching of the free layer always occurs
									ix=0.0;   //change the current state of MTJ
								end
							else
								begin
									ix=-1.0;

										end

						end
					else
						begin	//Current smaller than critical current

							//STT-MTJ dynamic behavior : Neel-Brown model
							tau=tau0*exp(Em*(1-abs(Id/Ic1))/(`kB*T));

							if(Vc>brown_threshold)
								begin
									if (Vc<0.8*Ic1*R1)
										begin

							       begin
								    duration=tau;
							       end

											if (duration<Pwidth)
					  							begin

															ix=0.0;   //change the current state of MTJ
														end
													else
														begin
															ix=-1.0;
														end

										end

								end
						end

	end

I(x)<+ix;	//Actualisation of the state of x with the value calculated

//Ttrans has the same function than x but it includes the time effects
V(Ttrans)<+transition(-ix,duration,1e-12,1e-12);

I(T1,T2)<+Id;	//Actualisation of the current of MTJ with the value calculated

end

 if(Temp_var==1)
                begin
                     V(n1) <+ ( V(T1,T2)*V(T1,T2) )/ ( R0*surface*lam/(thick_s ));   //Definition of the maximum incrase of temperature

                     I(n1,n2) <+ V(n1,n2) / resistor;	// RC circuit definition,RC circuit parallel
                     I(n2) <+ capacitor * (ddt(V(n2)));

                     V(Temp) <+  V(n2) + temp_init;
                end
           else
               begin
                     V(Temp) <+  temp_init;
               end
end

endmodule
